* NGSPICE file created from TOP.ext - technology: sky130A

.subckt TOP Q A VSS VDD
X0 Q A VDD VDD sky130_fd_pr__pfet_01v8 ad=0.3 pd=2.6 as=0.3 ps=2.6 w=1 l=0.15
X1 Q A VSS VSS sky130_fd_pr__nfet_01v8 ad=0.135 pd=1.5 as=0.135 ps=1.5 w=0.45 l=0.15
C0 A VDD 0.15271f
C1 Q A 0.08874f
C2 Q VDD 0.1357f
C3 Q VSS 0.71424f
C4 A VSS 0.62185f
C5 VDD VSS 0.68683f
.ends
